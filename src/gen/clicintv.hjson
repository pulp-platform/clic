// Copyright 2022 ETH Zurich and University of Bologna.
// Copyright and related rights are licensed under the Solderpad Hardware
// License, Version 0.51 (the "License"); you may not use this file except in
// compliance with the License.  You may obtain a copy of the License at
// http://solderpad.org/licenses/SHL-0.51. Unless required by applicable law
// or agreed to in writing, software, hardware and materials distributed under
// this License is distributed on an "AS IS" BASIS, WITHOUT WARRANTIES OR
// CONDITIONS OF ANY KIND, either express or implied. See the License for the
// specific language governing permissions and limitations under the License.

// SPDX-License-Identifier: Apache-2.0

// CLIC virtual supervisor interrupt register
{
  name: "CLICINTV",
  clock_primary: "clk_i",
  bus_interfaces: [
    { protocol: "reg_iface", direction: "device" }
  ],

  regwidth: "8",
  registers: [
    { name: "CLICINTV",
      desc: "CLIC interrupt virtualization",
      swaccess: "rw",
      hwaccess: "hro",
      fields: [
        { bits: "7:2", name: "VSID", desc: "interrupt VS id" },
        // { bits: "1", name: "reserved", desc: "reserved for future use"},
        { bits: "0", name: "V", desc: "interrupt delegated to VS-mode"},
      ],
    }
  ]
}
